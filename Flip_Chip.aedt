# Ansys Electronics Desktop project, version 2025.2
project datasets:
  $Cu_Pure_35: (-273.15, 0.49118388) (-196.15, 0.49118388) (99.85, 1) (726.85, 1)
  $Si_Typical_5: (-273.15, 0.23376623) (-196.15, 0.23376623) (99.85, 1) (726.85, 1)
materials:
  Al-Extruded: thermal_conductivity=205 mass_density=2800 specific_heat=900 youngs_modulus=69000000000 poissons_ratio=0.33 thermal_expansion_coefficient=2.277e-06 thermal_material_type=Solid
  air: permittivity=1.0006 permeability=1.0000004 thermal_conductivity=0.0261 mass_density=1.1614 specific_heat=1005 thermal_expansion_coefficient=0.00333 thermal_material_type=Fluid diffusivity=2.88e-05 molecular_mass=0.028966 viscosity=1.84e-05 material_refractive_index=1.000293
  Substrate_material: thermal_conductivity=0.35 mass_density=1900 specific_heat=795 thermal_material_type=Solid
  Cu-Pure: thermal_modifier{Property=specific_heat free_form_value=pwl($Cu_Pure_35,Temp)} thermal_conductivity=387.6 mass_density=8933 specific_heat=397 thermal_material_type=Solid
  Solder-pb50_sn50: thermal_conductivity=46 mass_density=8890 specific_heat=213 thermal_material_type=Solid
  Si-Typical: thermal_modifier{Property=specific_heat free_form_value=pwl($Si_Typical_5,Temp)} thermal_conductivity=180 mass_density=2330 specific_heat=770 thermal_material_type=Solid
  Flipchip_underfill: thermal_conductivity=0.8 mass_density=1210 specific_heat=1172 thermal_material_type=Solid
  Practical_Practice_1_FlipChip_BGA_trace1_material: thermal_conductivity=232.7 mass_density=6119.8 specific_heat=556.2
  Practical_Practice_1_FlipChip_BGA_trace2_material: thermal_conductivity=116.525 mass_density=4009.9 specific_heat=675.6
  Practical_Practice_1_FlipChip_BGA_trace3_material: thermal_conductivity=116.525 mass_density=4009.9 specific_heat=675.6
  Practical_Practice_1_FlipChip_BGA_trace4_material: thermal_conductivity=232.7 mass_density=6119.8 specific_heat=556.2
  Practical_Practice_1_FlipChip_BGA_substrate_material: thermal_conductivity{anisotropic component1=0.35 component2=0.35 component3=0.35} mass_density=1900 specific_heat=795
  Practical_Practice_1_FlipChip_BGA_via_material: thermal_conductivity{anisotropic component1=0.35 component2=0.35 component3=0.97262282} mass_density=1900 specific_heat=795
  Practical_Practice_1_FlipChip_BGA_underfill_material: thermal_conductivity{anisotropic component1=0.8 component2=0.8 component3=0.80949592} mass_density=1211.6135 specific_heat=1171.7985
  Practical_Project1_Flipchip_BGA_trace1_material: thermal_conductivity=213.3375 mass_density=5768.15 specific_heat=576.1
  Practical_Project1_Flipchip_BGA_substrate_material: thermal_conductivity{anisotropic component1=0.35 component2=0.35 component3=0.35} mass_density=1900 specific_heat=795
  Practical_Project1_Flipchip_BGA_via_material: thermal_conductivity{anisotropic component1=0.35 component2=0.35 component3=0.35} mass_density=1900 specific_heat=795
  Practical_Project1_Flipchip_BGA_underfill_material: thermal_conductivity{anisotropic component1=0.8 component2=0.8 component3=0.80949592} mass_density=1211.6135 specific_heat=1171.7985
surface materials:
  Steel-oxidised-surface: surface_emissivity=0.8

design IcepakDesign1 (Icepak, SteadyState TemperatureAndFlow, model units mm)
options: Default_Fluid_Material=air Default_Solid_Material=Al-Extruded Default_Surface_Material=Steel-oxidised-surface AmbientTemperature=20cel AmbientPressure=0n_per_meter_sq AmbientRadiationTemperature=20cel Gravity_Vector_CS_ID=Global Gravity_Vector_Axis=Z Positive=false Altitude=0meter OperatingPressure=101325n_per_meter_sq OperatingDensity=1.225kg_per_m3
geometry:
  Region [air] = region(percentage_offset=50 on all sides)
  Practical_Practice_1_FlipChip_BGA1 = component(Practical_Practice_1_FlipChip_BGA, 3D_Component_File_Path=C:/temp/Practical_Practice_1_FlipChip_BGA.a3dcomp)
  Practical_Practice_1_FlipChip_BGA_die, Practical_Practice_1_FlipChip_BGA_die_source [Si-Typical] = part_of(Practical_Practice_1_FlipChip_BGA1)
  Practical_Practice_1_FlipChip_BGA_die_underfill [Practical_Practice_1_FlipChip_BGA_underfill_material] = part_of(Practical_Practice_1_FlipChip_BGA1)
  Practical_Practice_1_FlipChip_BGA_substrate [Practical_Practice_1_FlipChip_BGA_substrate_material] = part_of(Practical_Practice_1_FlipChip_BGA1)
  Practical_Practice_1_FlipChip_BGA_via [Practical_Practice_1_FlipChip_BGA_via_material] = part_of(Practical_Practice_1_FlipChip_BGA1)
  Practical_Practice_1_FlipChip_BGA_trace1 [Practical_Practice_1_FlipChip_BGA_trace1_material] = part_of(Practical_Practice_1_FlipChip_BGA1)
  Practical_Practice_1_FlipChip_BGA_trace2 [Practical_Practice_1_FlipChip_BGA_trace2_material] = part_of(Practical_Practice_1_FlipChip_BGA1)
  Practical_Practice_1_FlipChip_BGA_trace3 [Practical_Practice_1_FlipChip_BGA_trace3_material] = part_of(Practical_Practice_1_FlipChip_BGA1)
  Practical_Practice_1_FlipChip_BGA_trace4 [Practical_Practice_1_FlipChip_BGA_trace4_material] = part_of(Practical_Practice_1_FlipChip_BGA1)
  Practical_Practice_1_FlipChip_BGA_ball, Practical_Practice_1_FlipChip_BGA_ball_1..Practical_Practice_1_FlipChip_BGA_ball_26, Practical_Practice_1_FlipChip_BGA_ball_1_1..Practical_Practice_1_FlipChip_BGA_ball_1_13, Practical_Practice_1_FlipChip_BGA_ball_2_1..Practical_Practice_1_FlipChip_BGA_ball_2_13, Practical_Practice_1_FlipChip_BGA_ball_3_1..Practical_Practice_1_FlipChip_BGA_ball_3_13, Practical_Practice_1_FlipChip_BGA_ball_4_1..Practical_Practice_1_FlipChip_BGA_ball_4_13, Practical_Practice_1_FlipChip_BGA_ball_5_1..Practical_Practice_1_FlipChip_BGA_ball_5_13, Practical_Practice_1_FlipChip_BGA_ball_6_1..Practical_Practice_1_FlipChip_BGA_ball_6_13, Practical_Practice_1_FlipChip_BGA_ball_7_1..Practical_Practice_1_FlipChip_BGA_ball_7_13, Practical_Practice_1_FlipChip_BGA_ball_8_1..Practical_Practice_1_FlipChip_BGA_ball_8_13, Practical_Practice_1_FlipChip_BGA_ball_9_1..Practical_Practice_1_FlipChip_BGA_ball_9_13, Practical_Practice_1_FlipChip_BGA_ball_10_1..Practical_Practice_1_FlipChip_BGA_ball_10_13, Practical_Practice_1_FlipChip_BGA_ball_11_1..Practical_Practice_1_FlipChip_BGA_ball_11_13, Practical_Practice_1_FlipChip_BGA_ball_12_1..Practical_Practice_1_FlipChip_BGA_ball_12_13, Practical_Practice_1_FlipChip_BGA_ball_13_1..Practical_Practice_1_FlipChip_BGA_ball_13_13 [Solder-pb50_sn50] = part_of(Practical_Practice_1_FlipChip_BGA1)
  Practical_Practice_1_FlipChip_BGA1.placement()
  Practical_Project1_Flipchip_BGA_die [Si-Typical] = box(corner=(0.0mm+ 0.5*15.0mm-0.5*8.56mm, 0.0mm+ 0.5*15.0mm-0.5*8.56mm, 0.0mm+0.5mm+0.36mm+0.01mm), size=(8.56mm, 8.56mm, 1.6mm-0.5mm-0.36mm-0.01mm-0.1mm))
  Practical_Project1_Flipchip_BGA_die_source [Si-Typical] = rectangle(corner=(0.0mm+ 0.5*15.0mm-0.5*8.56mm, 0.0mm+ 0.5*15.0mm-0.5*8.56mm, 0.0mm+0.5mm+0.36mm+0.01mm+1.6mm-0.5mm-0.36mm-0.01mm-0.1mm), x_size=8.56mm, y_size=8.56mm)
  Practical_Project1_Flipchip_BGA_die_underfill [Practical_Project1_Flipchip_BGA_underfill_material] = box(corner=(0.0mm+ 0.5*15.0mm-0.5*8.56mm, 0.0mm+ 0.5*15.0mm-0.5*8.56mm, 0.0mm+0.5mm+0.36mm), size=(8.56mm, 8.56mm, 0.01mm))
  Practical_Project1_Flipchip_BGA_substrate [Practical_Project1_Flipchip_BGA_substrate_material] = box(corner=(0mm, 0mm, 0.0mm+0.5mm+0.36mm-0.36mm), size=(15mm, 15mm, 0.36mm))
  Practical_Project1_Flipchip_BGA_via [Practical_Project1_Flipchip_BGA_via_material] = box(corner=(0.0mm+ 0.5*15.0mm-0.5*8.56mm, 0.0mm+ 0.5*15.0mm-0.5*8.56mm, 0.0mm+0.5mm+0.36mm-1*0.36mm), size=(8.56mm, 8.56mm, 0.36mm))
  Practical_Project1_Flipchip_BGA_trace1 [Practical_Project1_Flipchip_BGA_trace1_material] = rectangle(corner=(0mm, 0mm, 0.0mm+0.5mm+0.36mm), x_size=15mm, y_size=15mm)
  Practical_Project1_Flipchip_BGA_ball [Solder-pb50_sn50] = box(corner=(0.0mm+(0.5*(15.0mm-((1.0mm*14)-(1.0mm-0.443113462726mm)))), 0.0mm+(0.5*(15.0mm-((1.0mm*14)-(1.0mm-0.443113462726mm)))), 0mm), size=(0.44311346mm, 0.44311346mm, 0.5mm))
  Practical_Project1_Flipchip_BGA_ball_1..Practical_Project1_Flipchip_BGA_ball_13 [Solder-pb50_sn50] = Practical_Project1_Flipchip_BGA_ball.duplicate_along_line(step=(1mm, 0mm, 0mm), total=14)
  Practical_Project1_Flipchip_BGA_ball_14..Practical_Project1_Flipchip_BGA_ball_26 [Solder-pb50_sn50] = Practical_Project1_Flipchip_BGA_ball.duplicate_along_line(step=(0mm, 1mm, 0mm), total=14)
  Practical_Project1_Flipchip_BGA_ball_1_1..Practical_Project1_Flipchip_BGA_ball_1_13 [Solder-pb50_sn50] = Practical_Project1_Flipchip_BGA_ball_1.duplicate_along_line(step=(0mm, 1mm, 0mm), total=14)
  Practical_Project1_Flipchip_BGA_ball_2_1..Practical_Project1_Flipchip_BGA_ball_2_13 [Solder-pb50_sn50] = Practical_Project1_Flipchip_BGA_ball_2.duplicate_along_line(step=(0mm, 1mm, 0mm), total=14)
  Practical_Project1_Flipchip_BGA_ball_3_1..Practical_Project1_Flipchip_BGA_ball_3_13 [Solder-pb50_sn50] = Practical_Project1_Flipchip_BGA_ball_3.duplicate_along_line(step=(0mm, 1mm, 0mm), total=14)
  Practical_Project1_Flipchip_BGA_ball_4_1..Practical_Project1_Flipchip_BGA_ball_4_13 [Solder-pb50_sn50] = Practical_Project1_Flipchip_BGA_ball_4.duplicate_along_line(step=(0mm, 1mm, 0mm), total=14)
  Practical_Project1_Flipchip_BGA_ball_5_1..Practical_Project1_Flipchip_BGA_ball_5_13 [Solder-pb50_sn50] = Practical_Project1_Flipchip_BGA_ball_5.duplicate_along_line(step=(0mm, 1mm, 0mm), total=14)
  Practical_Project1_Flipchip_BGA_ball_6_1..Practical_Project1_Flipchip_BGA_ball_6_13 [Solder-pb50_sn50] = Practical_Project1_Flipchip_BGA_ball_6.duplicate_along_line(step=(0mm, 1mm, 0mm), total=14)
  Practical_Project1_Flipchip_BGA_ball_7_1..Practical_Project1_Flipchip_BGA_ball_7_13 [Solder-pb50_sn50] = Practical_Project1_Flipchip_BGA_ball_7.duplicate_along_line(step=(0mm, 1mm, 0mm), total=14)
  Practical_Project1_Flipchip_BGA_ball_8_1..Practical_Project1_Flipchip_BGA_ball_8_13 [Solder-pb50_sn50] = Practical_Project1_Flipchip_BGA_ball_8.duplicate_along_line(step=(0mm, 1mm, 0mm), total=14)
  Practical_Project1_Flipchip_BGA_ball_9_1..Practical_Project1_Flipchip_BGA_ball_9_13 [Solder-pb50_sn50] = Practical_Project1_Flipchip_BGA_ball_9.duplicate_along_line(step=(0mm, 1mm, 0mm), total=14)
  Practical_Project1_Flipchip_BGA_ball_10_1..Practical_Project1_Flipchip_BGA_ball_10_13 [Solder-pb50_sn50] = Practical_Project1_Flipchip_BGA_ball_10.duplicate_along_line(step=(0mm, 1mm, 0mm), total=14)
  Practical_Project1_Flipchip_BGA_ball_11_1..Practical_Project1_Flipchip_BGA_ball_11_13 [Solder-pb50_sn50] = Practical_Project1_Flipchip_BGA_ball_11.duplicate_along_line(step=(0mm, 1mm, 0mm), total=14)
  Practical_Project1_Flipchip_BGA_ball_12_1..Practical_Project1_Flipchip_BGA_ball_12_13 [Solder-pb50_sn50] = Practical_Project1_Flipchip_BGA_ball_12.duplicate_along_line(step=(0mm, 1mm, 0mm), total=14)
  Practical_Project1_Flipchip_BGA_ball_13_1..Practical_Project1_Flipchip_BGA_ball_13_13 [Solder-pb50_sn50] = Practical_Project1_Flipchip_BGA_ball_13.duplicate_along_line(step=(0mm, 1mm, 0mm), total=14)
  SubRegion [air, non-model] = sub_region(of=Practical_Project1_Flipchip_BGA_die_underfill, percentage_offset=0 on all sides)
  MeshRegion1_SubRegion [air, non-model] = sub_region(of=Practical_Project1_Flipchip_BGA_ball, percentage_offset=0 on all sides)
  SubRegion1 [air, non-model] = sub_region(of=Practical_Project1_Flipchip_BGA_die_source, percentage_offset=0 on all sides)
  group Practical_Project1_Flipchip_BGA_Group = Practical_Project1_Flipchip_BGA_die, Practical_Project1_Flipchip_BGA_die_source, Practical_Project1_Flipchip_BGA_die_underfill, Practical_Project1_Flipchip_BGA_substrate, Practical_Project1_Flipchip_BGA_via, Practical_Project1_Flipchip_BGA_trace1
  group Practical_Project1_Flipchip_BGA_ball_Group = Practical_Project1_Flipchip_BGA_ball, Practical_Project1_Flipchip_BGA_ball_1..Practical_Project1_Flipchip_BGA_ball_26, Practical_Project1_Flipchip_BGA_ball_1_1..Practical_Project1_Flipchip_BGA_ball_1_13, Practical_Project1_Flipchip_BGA_ball_2_1..Practical_Project1_Flipchip_BGA_ball_2_13, Practical_Project1_Flipchip_BGA_ball_3_1..Practical_Project1_Flipchip_BGA_ball_3_13, Practical_Project1_Flipchip_BGA_ball_4_1..Practical_Project1_Flipchip_BGA_ball_4_13, Practical_Project1_Flipchip_BGA_ball_5_1..Practical_Project1_Flipchip_BGA_ball_5_13, Practical_Project1_Flipchip_BGA_ball_6_1..Practical_Project1_Flipchip_BGA_ball_6_13, Practical_Project1_Flipchip_BGA_ball_7_1..Practical_Project1_Flipchip_BGA_ball_7_13, Practical_Project1_Flipchip_BGA_ball_8_1..Practical_Project1_Flipchip_BGA_ball_8_13, Practical_Project1_Flipchip_BGA_ball_9_1..Practical_Project1_Flipchip_BGA_ball_9_13, Practical_Project1_Flipchip_BGA_ball_10_1..Practical_Project1_Flipchip_BGA_ball_10_13, Practical_Project1_Flipchip_BGA_ball_11_1..Practical_Project1_Flipchip_BGA_ball_11_13, Practical_Project1_Flipchip_BGA_ball_12_1..Practical_Project1_Flipchip_BGA_ball_12_13, Practical_Project1_Flipchip_BGA_ball_13_1..Practical_Project1_Flipchip_BGA_ball_13_13
boundaries and excitations:
  Practical_Practice_1_FlipChip_BGA1_Practical_Practice_1_FlipChip_BGA_die_source: Source Objects=Practical_Practice_1_FlipChip_BGA_die_source Thermal_Condition="Total Power" Total_Power=1W
  Practical_Practice_1_FlipChip_BGA1_Practical_Practice_1_FlipChip_BGA_trace1: Conducting Plate Objects=Practical_Practice_1_FlipChip_BGA_trace1 Thermal_Specification=Thickness Thickness=0.033mm Solid_Material=Practical_Practice_1_FlipChip_BGA1:Practical_Practice_1_FlipChip_BGA_trace1_material Total_Power=0W Shell_Conduction
  Practical_Practice_1_FlipChip_BGA1_Practical_Practice_1_FlipChip_BGA_trace2: Conducting Plate Objects=Practical_Practice_1_FlipChip_BGA_trace2 Thermal_Specification=Thickness Thickness=0.033mm Solid_Material=Practical_Practice_1_FlipChip_BGA1:Practical_Practice_1_FlipChip_BGA_trace2_material Total_Power=0W Shell_Conduction
  Practical_Practice_1_FlipChip_BGA1_Practical_Practice_1_FlipChip_BGA_trace3: Conducting Plate Objects=Practical_Practice_1_FlipChip_BGA_trace3 Thermal_Specification=Thickness Thickness=0.033mm Solid_Material=Practical_Practice_1_FlipChip_BGA1:Practical_Practice_1_FlipChip_BGA_trace3_material Total_Power=0W Shell_Conduction
  Practical_Practice_1_FlipChip_BGA1_Practical_Practice_1_FlipChip_BGA_trace4: Conducting Plate Objects=Practical_Practice_1_FlipChip_BGA_trace4 Thermal_Specification=Thickness Thickness=0.033mm Solid_Material=Practical_Practice_1_FlipChip_BGA1:Practical_Practice_1_FlipChip_BGA_trace4_material Total_Power=0W Shell_Conduction
  Practical_Project1_Flipchip_BGA_die_source: Source Objects=Practical_Project1_Flipchip_BGA_die_source Thermal_Condition="Total Power" Total_Power=1W
  Source1: Source Objects=Practical_Project1_Flipchip_BGA_substrate Thermal_Condition="Fixed Temperature" Temperature=AmbientTemp
mesh:
  Global:  MeshMethod=MesherHD ComputeGap MeshRegionResolution=3 GeometryBasedMeshing MinGapX=1mm MinGapY=1mm MinGapZ=0.3mm Objects=Region FacetLevel=3 ProximitySizeFunction CurvatureSizeFunction OptimizePCBMesh
  MeshRegion1:  MeshMethod=MesherHD MeshRegionResolution=3 GeometryBasedMeshing MinGapX=0.044311346mm MinGapY=0.044311346mm MinGapZ=0.05mm Objects=MeshRegion1_SubRegion ProximitySizeFunction CurvatureSizeFunction OptimizePCBMesh
monitors:
  Practical_Project1_Flipchip_BGA_substrate: Quantities(19) Objects=Practical_Project1_Flipchip_BGA_substrate
  Practical_Project1_Flipchip_BGA_die: Quantities(19) Objects=Practical_Project1_Flipchip_BGA_die
  Practical_Project1_Flipchip_BGA_die_underfill: Quantities(19) Objects=Practical_Project1_Flipchip_BGA_die_underfill
setups:
  Setup1: IcepakSteadyState Flow_Regime=Laminar Include_Temperature=true Include_Flow=true Convergence_Criteria_-_Flow=0.001 Convergence_Criteria_-_Energy=1e-07 GPU_Convergence_Criteria_-_Flow=0.001 GPU_Convergence_Criteria_-_Energy=1e-05 disabled Radiation_Model=Off Under-relaxation_-_Pressure=0.3 Under-relaxation_-_Momentum=0.7 Under-relaxation_-_Temperature=1 Under-relaxation_-_Body_Force=1 Discretization_Scheme_-_Pressure=Standard Discretization_Scheme_-_Momentum=First Discretization_Scheme_-_Temperature=First Convergence_Criteria_-_Max_Iterations=100
field plots:
  Temperature1: Temperature on Setup1 : SteadyState
